* Experimental Rust-backed XSPICE EDGE ALB, original SIMetrix 9.40d source.
* Physical source/bridge timing is compared to vendor-q-2p5v-events.csv.
Vdata d 0 PWL(0 0 5n 0 5.1n 5 15n 5 15.1n 0 25n 0 25.1n 5 35n 5 35.1n 0 52n 0)
Vclock ck 0 PWL(0 0 9.9n 0 10n 5 13n 5 13.1n 0 19.9n 0 20n 5 23n 5 23.1n 0 29.9n 0 30n 5 33n 5 33.1n 0 39.9n 0 40n 5 43n 5 43.1n 0 52n 0)
AadcD %gd(d 0) dd d_sink d_source ADC
AadcC %gd(ck 0) dc c_sink c_source ADC
.model ADC sr_family_adc(in_low=2.1 in_high=2.2 rise_delay=1p fall_delay=1p out_low=0 out_high=5 clamp_low=0 clamp_high=5 clamp_res=10 clamp_bias=.5 schmitt=true time_tol=20p)
Aseq [dd dc] [dq] 0 [q_sink] [q_source] STATE
.model STATE sr_alb_stateful(source_hex="504f5254204461746120696e5b305d3b20504f525420436c6f636b20696e5b315d3b20504f5254202844454c41593d32353070292051206f75745b305d3b2045444745202857494454483d312c2044454c41593d373530702c20434c4f434b3d696e5b315d2920466c69703d303b20466c6970203d20446174613b2051203d20466c69703b" reg_delay=1n port_delay=1n)
Adac dq q_sink q_source %gd(q 0) DAC
.model DAC sr_family_dac(out_low=0 out_high=5 g_pullup=.024 g_pulldown=.034 g_resistive=.001 g_hiz=1e-9 knee_low=2 knee_high=2.75 v_smooth=.5 input_load=-31p t_rise=2n t_fall=2n sink_current=0 source_current=0)
Rout q 0 100k
.tran 20p 52n 0 20p
.control
run
wrdata stateful-edge.dat v(q) v(d) v(ck)
quit
.endc
.end
