* loaded
Vin ain 0 PULSE(0 1 1n 1p 1p 15n 40n)
Aadc [ain] [din] ADC
.model ADC adc_bridge(in_low=0.25 in_high=0.75 rise_delay=1p fall_delay=1p)
Aalb din dout 0 ALB
.model ALB sr_alb_probe(delay=5n input_load=4.5p out_res=1000 ic=0 inertial_delay=true)
Aload dout dummy LOAD
.model LOAD d_buffer(input_load=5p rise_delay=1p fall_delay=1p inertial_delay=true)
Adac [dout] [aout] DAC
.model DAC dac_bridge(out_low=0 out_high=1 input_load=0 t_rise=1p t_fall=1p)
Rout aout 0 1k
.tran 1p 24n
.control
run
wrdata loaded.dat v(aout)
quit
.endc
.end
