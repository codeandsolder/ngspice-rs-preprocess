* LUT startup from DC-high input without a later input edge
Vin ain 0 1
Aadc [ain] [da] ADC
.model ADC adc_bridge(in_low=.25 in_high=.75 rise_delay=1p fall_delay=1p)
Alut [da] dout dout_sink dout_source 0 LUT
.model LUT sr_alb_lut_bit(table_values="01" delay=3n input_load=1p out_res_pos=0 out_res_neg=0 ic=0 inertial_delay=true)
Adac [dout] [aout] DAC
.model DAC dac_bridge(out_low=0 out_high=1 input_load=0 t_rise=1p t_fall=1p)
Rout aout 0 1k
.tran 1p 7n
.control
run
wrdata lut-startup.dat v(aout)
quit
.endc
.end
