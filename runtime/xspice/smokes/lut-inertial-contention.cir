* Inertial event rollback while a second STRONG driver contends or drives a Z output
Vin ain 0 PWL(0n 0 1n 0 1.001n 1 3n 1 3.001n 0 7n 0 7.001n 1 15n 1 15.001n 0 19n 0 19.001n 1 21n 1 21.001n 0)
Aadc [ain] [din] ADC
.model ADC adc_bridge(in_low=.25 in_high=.75 rise_delay=1p fall_delay=1p)
* Bus L: pulse HIGH competes with constant low; short HIGH must be rejected.
Acontend [din] buslow blsink blsource 0 BINARY
.model BINARY sr_alb_lut_bit(table_values="01" delay=5n input_load=0 out_res_pos=0 out_res_neg=0 ic=0 inertial_delay=true)
Alow [din] buslow flsink flsource 0 FORCEL
.model FORCEL sr_alb_lut_bit(table_values="00" delay=1n input_load=0 out_res_pos=0 out_res_neg=0 ic=0 inertial_delay=true)
* Bus Z: temporary Z releases bus to the strong high driver; short Z must be rejected.
Arelease [din] busz bzsink bzsource 0 TRISTATE
.model TRISTATE sr_alb_lut_bit(table_values="0Z" delay=5n input_load=0 out_res_pos=0 out_res_neg=0 ic=0 inertial_delay=true)
Ahigh [din] busz fhsink fhsource 0 FORCEH
.model FORCEH sr_alb_lut_bit(table_values="11" delay=1n input_load=0 out_res_pos=0 out_res_neg=0 ic=1 inertial_delay=true)
* Loaded bus adds 4pF: the same 8ns pulse is shorter than its 9ns inertial delay.
Aloaded [din] busload ldsink ldsource 0 LOADED
.model LOADED sr_alb_lut_bit(table_values="01" delay=5n input_load=0 out_res_pos=1k out_res_neg=1k ic=0 inertial_delay=true)
Alowloaded [din] busload lfsink lfsource 0 FORCEL
Aload1 busload ldsink ldsource CAP
Aload2 busload ldsink ldsource CAP
.model CAP sr_bundle_load(capacitance=2p sink_current=0 source_current=0)
* Transport counterpart preserves the 2ns pulse, unlike inertial variants.
Atransport [din] bustrans tdsink tdsource 0 TRANSPORT
.model TRANSPORT sr_alb_lut_bit(table_values="01" delay=5n input_load=0 out_res_pos=0 out_res_neg=0 ic=0 inertial_delay=false)
Alowtrans [din] bustrans tfsink tfsource 0 FORCEL
Adacl [buslow] [outlow] DAC
Adacz [busz] [outz] DAC
Adacloaded [busload] [outload] DAC
Adactrans [bustrans] [outtrans] DAC
.model DAC dac_bridge(out_low=0 out_high=1 out_undef=.5 input_load=0 t_rise=1p t_fall=1p)
Routl outlow 0 10k
Routz outz 0 10k
Routload outload 0 10k
Routtrans outtrans 0 10k
.tran 5p 32n
.control
run
wrdata lut-inertial-contention.dat v(outlow) v(outz) v(outload) v(outtrans)
quit
.endc
.end
