* Native possible-state consensus under simultaneous known and unknown input bits
Va a 0 PULSE(0 1 7n 1p 1p 12n 35n)
Vx x 0 .5
Vh h 0 1
Vpull pull 0 .8
Aadc [a x h] [da dx dh] ADC
.model ADC adc_bridge(in_low=.25 in_high=.75 rise_delay=1p fall_delay=1p)
Aand [da dx] dyand dyand_sink dyand_source 0 AND
.model AND sr_alb_lut_bit(table_values="0001" delay=1n input_load=0 out_res_pos=0 out_res_neg=0 ic=0 inertial_delay=true)
Aor [da dx] dyor dyor_sink dyor_source 0 OR
.model OR sr_alb_lut_bit(table_values="0111" delay=1n input_load=0 out_res_pos=0 out_res_neg=0 ic=0 inertial_delay=true)
Axor [dh dx] dyxor dyxor_sink dyxor_source 0 XOR
.model XOR sr_alb_lut_bit(table_values="0110" delay=1n input_load=0 out_res_pos=0 out_res_neg=0 ic=0 inertial_delay=true)
Aallzero [dx dx dx] dzero dzero_sink dzero_source 0 ALLZERO
.model ALLZERO sr_alb_lut_bit(table_values="00000000" delay=1n input_load=0 out_res_pos=0 out_res_neg=0 ic=0 inertial_delay=true)
Aallone [dx dx dx] done done_sink done_source 0 ALLONE
.model ALLONE sr_alb_lut_bit(table_values="11111111" delay=1n input_load=0 out_res_pos=0 out_res_neg=0 ic=0 inertial_delay=true)
Amasked [dx dh dx] dmasked dmasked_sink dmasked_source 0 MASKED
.model MASKED sr_alb_lut_bit(table_values="00110011" delay=1n input_load=0 out_res_pos=0 out_res_neg=0 ic=0 inertial_delay=true)
Aallz [dx] dz dz_sink dz_source 0 ALLZ
.model ALLZ sr_alb_lut_bit(table_values="zZ" delay=1n input_load=0 out_res_pos=0 out_res_neg=0 ic=0 inertial_delay=true)
Amixz [dx] dmix dmix_sink dmix_source 0 MIXZ
.model MIXZ sr_alb_lut_bit(table_values="0Z" delay=1n input_load=0 out_res_pos=0 out_res_neg=0 ic=0 inertial_delay=true)
* STRONG 1 must override unanimous HI_Z, but not an UNDETERMINED
* output produced by disagreement between 0 and Z rows.
AforceZ [dh] dz dzforce_sink dzforce_source 0 FORCE
AforceMix [dh] dmix dmixforce_sink dmixforce_source 0 FORCE
.model FORCE sr_alb_lut_bit(table_values="11" delay=1n input_load=0 out_res_pos=0 out_res_neg=0 ic=1 inertial_delay=true)
Adacand [dyand] [aand] DAC
Adacor [dyor] [aor] DAC
Adacxor [dyxor] [axor] DAC
Adaczero [dzero] [azero] DAC
Adacone [done] [aone] DAC
Adacmasked [dmasked] [amasked] DAC
Adacz [dz] [az] DAC
Adacmix [dmix] [amix] DAC
.model DAC dac_bridge(out_low=0 out_high=1 out_undef=.5 input_load=0 t_rise=1p t_fall=1p)
Randa aand 0 10k
Rora aor 0 10k
Rxora axor 0 10k
Rzero azero 0 10k
Rone aone 0 10k
Rmasked amasked 0 10k
Rpullup az pull 1k
Rmix amix 0 10k
.tran 5p 17n
.control
run
wrdata lut-consensus.dat v(aand) v(aor) v(axor) v(azero) v(aone) v(az) v(amix) v(amasked)
quit
.endc
.end
