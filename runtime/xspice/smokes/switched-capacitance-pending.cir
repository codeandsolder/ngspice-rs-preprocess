* XSPICE fixed digital LOAD() versus an independently switched analog capacitor.
* The switch closes at 12ns, while the event requested at ~10.051ns
* remains queued until ~17.051ns. LOAD() is INIT-only in ngspice XSPICE;
* the 2pF published digital load stays fixed for all three CCAP values.
* The analog VOUT voltage must obey the real nonlinear DAC and capacitor.
.param CCAP=150p
Vin ain 0 PWL(0 0 10n 0 10.1n 3.3 70n 3.3 70.1n 0 90n 0)
Vload gate 0 PWL(0 0 12n 0 12.1n 3.3 50n 3.3 50.1n 0 90n 0)
Aadc [ain] [din] ADC
.model ADC adc_bridge(in_low=1.386 in_high=1.452 rise_delay=1p fall_delay=1p)
Alut [din] dout sink source 0 LUT
.model LUT sr_alb_lut_bit(table_values="01" delay=5n input_load=0 out_res_pos=1k out_res_neg=1k ic=0 inertial_delay=true)
Aload dout sink source LOAD
.model LOAD sr_bundle_load(capacitance=2p sink_current=0 source_current=0)
Adac dout sink source %gd(vout 0) DAC
.model DAC sr_family_dac(out_low=0 out_high=3.3 g_pullup=.024 g_pulldown=.034 g_resistive=.001 g_hiz=1e-8 knee_low=2 knee_high=2.75 v_smooth=.5 input_load=0 t_rise=50p t_fall=50p)
Rout vout 0 1k
Cbase vout 0 2p
Sload vout capnode gate 0 CLOAD
Vcapsense capnode capterminal 0
Cextra capterminal 0 {CCAP}
Rleak capterminal 0 10Meg
.model CLOAD SW(Ron=33 Roff=1e12 Vt=1.65 Vh=.1)
.tran 20p 90n 0 20p
.control
run
eprint din dout > digital-events.txt
wrdata result.dat v(vout) v(ain) v(gate) v(capterminal) i(Vcapsense) v(capnode)
quit
.endc
.end
