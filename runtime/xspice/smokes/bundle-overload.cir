* three-node digital bundle overload probe
Vin ain 0 PULSE(0 1 1n 1p 1p 20n 50n)
Aadc [ain] [din] ADC
.model ADC adc_bridge(in_low=.25 in_high=.75 rise_delay=1p fall_delay=1p)
Adrv din state sinkmeta sourcemeta 0 DRV
.model DRV sr_bundle_driver(delay=2n out_res=1k min_sink=-20m max_source=20m ic=0 inertial_delay=true)
Aload1 state sinkmeta sourcemeta L
Aload2 state sinkmeta sourcemeta L
Aload3 state sinkmeta sourcemeta L
.model L sr_bundle_load(capacitance=2p sink_current=-10m source_current=10m)
Adac [state] [aout] DAC
.model DAC dac_bridge(out_low=0 out_high=1 out_undef=.5 input_load=0 t_rise=1p t_fall=1p)
Rout aout 0 1k
.tran 1p 30n
.control
run
wrdata out.dat v(aout)
quit
.endc
.end
