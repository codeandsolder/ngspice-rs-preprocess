* two cascaded timed LUTs; a 2ns buffer then 3ns inverter
Va ain 0 PULSE(0 1 1n 1p 1p 10n 30n)
Aadc [ain] [da] ADC
.model ADC adc_bridge(in_low=.25 in_high=.75 rise_delay=1p fall_delay=1p)
Afirst [da] dmid dmid_sink dmid_source 0 FIRST
.model FIRST sr_alb_lut_bit(table_values="01" delay=2n input_load=4p out_res_pos=0 out_res_neg=0 ic=0 inertial_delay=true)
Asecond [dmid] dout dout_sink dout_source 0 SECOND
.model SECOND sr_alb_lut_bit(table_values="10" delay=3n input_load=4p out_res_pos=0 out_res_neg=0 ic=1 inertial_delay=true)
Adac [dout] [aout] DAC
.model DAC dac_bridge(out_low=0 out_high=1 input_load=0 t_rise=1p t_fall=1p)
Rout aout 0 1k
.tran 1p 12n
.control
run
wrdata lut-chain.dat v(aout)
quit
.endc
.end
