* ngspice analog RC load reflection on digital output
Vin vin 0 PULSE(0 5 1n 1p 1p 30n 80n)
Rin vin ain 1k
Aadc %gd(ain 0) dout dout_sink dout_source HC_ADC
.model HC_ADC sr_family_adc(in_low=2.1 in_high=2.2 rise_delay=1p fall_delay=1p out_low=0 out_high=5 clamp_low=0 clamp_high=5 clamp_bias=.5 clamp_res=10)
Aload dout dout_sink dout_source L
.model L sr_bundle_load(capacitance=2p sink_current=0 source_current=0)
Adac [dout] [aout] OUTDAC
.model OUTDAC dac_bridge(out_low=0 out_high=1 out_undef=.5 input_load=0 t_rise=1p t_fall=1p)
Rout aout 0 1k
.tran 1p 20n
.control
run
wrdata out.dat v(ain)
quit
.endc
.end
