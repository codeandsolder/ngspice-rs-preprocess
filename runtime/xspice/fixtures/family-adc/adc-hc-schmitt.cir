* Schmitt: start low in threshold band, rise, hold, then fall
Vin ain 0 PWL(0 1.45 5n 1.45 10n 1.6 15n 1.45 20n 1.3 25n 1.45 28n 1.45)
Aadc %gd(ain 0) dout dout_sink dout_source HC_SCHMITT
.model HC_SCHMITT sr_family_adc(in_low=1.4 in_high=1.5 rise_delay=1p fall_delay=1p schmitt=true ic=0 out_low=0 out_high=3.5 clamp_low=0 clamp_high=3.5 clamp_bias=.5 clamp_res=10)
Adac [dout] [aout] OUTDAC
.model OUTDAC dac_bridge(out_low=0 out_high=1 out_undef=.5 input_load=0 t_rise=1p t_fall=1p)
Rout aout 0 1k
.tran 20p 28n
.control
run
wrdata out.dat v(aout)
quit
.endc
.end
