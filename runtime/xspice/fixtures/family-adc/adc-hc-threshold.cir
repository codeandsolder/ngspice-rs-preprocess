* HC ADC thresholds with a 100ns 0..5V ramp and digital readout
Vin ain 0 PWL(0 0 10n 0 110n 5 120n 5 220n 0 230n 0)
Aadc %gd(ain 0) dout dout_sink dout_source HC_ADC
.model HC_ADC sr_family_adc(in_low=2.1 in_high=2.2 rise_delay=2n fall_delay=3n out_low=0 out_high=5 clamp_low=0 clamp_high=5 clamp_bias=.5 clamp_res=10)
Adac [dout] [aout] OUTDAC
.model OUTDAC dac_bridge(out_low=0 out_high=1 out_undef=.5 input_load=0 t_rise=1p t_fall=1p)
Rout aout 0 1k
.tran 50p 230n
.control
run
wrdata out.dat v(aout)
quit
.endc
.end
