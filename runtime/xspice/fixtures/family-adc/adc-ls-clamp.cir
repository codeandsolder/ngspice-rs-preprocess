* LS family ADC: upper clamp near breakdown 15V, not 3.5V logic rail
Vtest input 0 0
Aadc %gd(input 0) dout dout_sink dout_source LS_ADC
.model LS_ADC sr_family_adc(in_low=1.4 in_high=1.5 rise_delay=1p fall_delay=1.4n out_low=0 out_high=3.5 clamp_low=0 clamp_high=15 clamp_bias=1 clamp_res=2.5)
.dc Vtest -2 18 .25
.control
run
wrdata out.dat i(Vtest)
quit
.endc
.end
