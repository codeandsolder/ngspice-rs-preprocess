* Schmitt ADC threshold time tolerance with deliberately coarse analog intervals
Vin ain 0 PWL(0 0 1u 5 2u 5 3u 0 4u 0)
Aadc %gd(ain 0) dout dout_sink dout_source MODEL
.model MODEL sr_family_adc(in_low=2.1 in_high=2.2 rise_delay=1p fall_delay=1p out_low=0 out_high=5 clamp_low=-10 clamp_high=20 clamp_bias=.5 clamp_res=10 time_tol=10p schmitt=true ic=0)
Adac [dout] [out] CONV
.model CONV dac_bridge(out_low=0 out_high=1 out_undef=.5 input_load=0 t_rise=1p t_fall=1p)
Rload out 0 1k
.tran 200n 4u 0 200n
.control
run
wrdata out.dat v(out)
quit
.endc
.end
