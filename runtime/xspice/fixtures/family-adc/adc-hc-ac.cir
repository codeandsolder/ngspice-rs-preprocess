* HC ADC input with 2nF physical C and -10mA/20mA static load
Vtest input 0 DC 2 AC 1
Aadc %gd(input 0) dout dout_sink dout_source HC_ADC
.model HC_ADC sr_family_adc(in_low=2.1 in_high=2.2 rise_delay=1p fall_delay=1p out_low=0 out_high=5 clamp_low=0 clamp_high=5 clamp_bias=.5 clamp_res=10)
Aload dout dout_sink dout_source L
.model L sr_bundle_load(capacitance=2n sink_current=-10m source_current=20m)
Adac [dout] [aout] OUTDAC
.model OUTDAC dac_bridge(out_low=0 out_high=1 out_undef=.5 input_load=0 t_rise=1p t_fall=1p)
Rout aout 0 1k
.ac lin 1 1k 1k
.control
run
wrdata out.dat i(Vtest)
quit
.endc
.end
