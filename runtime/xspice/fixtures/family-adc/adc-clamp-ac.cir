* HC clamp differential conductance on both diode branches and knees
Vld ld 0 DC -.45 AC 1
Vlk lk 0 DC -.5 AC 1
Vll ll 0 DC -.55 AC 1
Vhd hd 0 DC 5.45 AC 1
Vhk hk 0 DC 5.5 AC 1
Vhl hl 0 DC 5.55 AC 1
Ald %gd(ld 0) ld_d ld_s ld_p ADC
Alk %gd(lk 0) lk_d lk_s lk_p ADC
All %gd(ll 0) ll_d ll_s ll_p ADC
Ahd %gd(hd 0) hd_d hd_s hd_p ADC
Ahk %gd(hk 0) hk_d hk_s hk_p ADC
Ahl %gd(hl 0) hl_d hl_s hl_p ADC
.model ADC sr_family_adc(in_low=2.1 in_high=2.2 out_low=0 out_high=5 clamp_low=0 clamp_high=5 clamp_res=10 clamp_bias=.5)
.ac lin 1 1k 1k
.control
run
wrdata out.dat i(Vld) i(Vlk) i(Vll) i(Vhd) i(Vhk) i(Vhl)
quit
.endc
.end
