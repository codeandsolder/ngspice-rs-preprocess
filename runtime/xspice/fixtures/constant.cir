* Rust-emitted zero-fanin ALB constant despite an unused input pin
Vin ain 0 0
Aadc [ain] [da] ADC
.model ADC adc_bridge(in_low=.25 in_high=.75 rise_delay=1p fall_delay=1p)
Xalb da da_sink da_source dout dout_sink dout_source ALB_CONSTANT
Adac [dout] [aout] DAC
.model DAC dac_bridge(out_low=0 out_high=1 out_undef=.5 input_load=0 t_rise=1p t_fall=1p)
Rout aout 0 1k
.include "generated.inc"
.tran 1p 8n
.control
run
wrdata generated.dat v(aout)
quit
.endc
.end
