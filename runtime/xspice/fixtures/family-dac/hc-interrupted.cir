* Nonlinear family DAC regression: hc-interrupted
Vin ain 0 PWL(0 0 4n 0 4.001n 1 4.801n 1 4.802n 0 6.001n 0 6.002n 1 11n 1)
Aadc [ain] [din] ADC
.model ADC adc_bridge(in_low=.25 in_high=.75 rise_delay=1p fall_delay=1p)
Afam din din_sink din_source %gd(vout 0) FAM
.model FAM sr_family_dac(out_low=0 out_high=5 g_pullup=.024 g_pulldown=.034 g_resistive=.001 g_hiz=1e-8 knee_low=2 knee_high=2.75 v_smooth=.5 input_load=0 t_rise=2n t_fall=2n)
Rload vout 0 10k
.tran 2p 11n
.control
run
wrdata out.dat v(vout)
quit
.endc
.end
