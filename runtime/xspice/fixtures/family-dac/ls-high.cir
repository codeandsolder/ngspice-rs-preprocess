* Nonlinear family DAC regression: ls-high
Vin ain 0 1
Aadc [ain] [din] ADC
.model ADC adc_bridge(in_low=.25 in_high=.75 rise_delay=1p fall_delay=1p)
Afam din din_sink din_source %gd(vout 0) FAM
.model FAM sr_family_dac(out_low=0 out_high=3.5 g_pullup=.0055 g_pulldown=.050 g_resistive=.001 g_hiz=1e-8 knee_low=.65 knee_high=0 v_smooth=0 input_load=0 t_rise=2.5n t_fall=2.5n)
Vtest vout 0 0
.dc Vtest -1 7 .25
.control
run
wrdata out.dat i(Vtest)
quit
.endc
.end
