* HC family DAC AC Jacobian regression at 4V
Vin ain 0 0
Aadc [ain] [din] ADC
.model ADC adc_bridge(in_low=.25 in_high=.75 rise_delay=1p fall_delay=1p)
Afam din din_sink din_source %gd(vout 0) FAM
.model FAM sr_family_dac(out_low=0 out_high=5 g_pullup=.024 g_pulldown=.034 g_resistive=.001 g_hiz=1e-8 knee_low=2 knee_high=2.75 v_smooth=.5 input_load=0)
Vtest vout 0 DC 4 AC 1
.ac lin 1 1k 1k
.control
run
wrdata out.dat i(Vtest)
quit
.endc
.end
