* Nonlinear family DAC regression: bundle-underlimit
Vin ain 0 PULSE(0 1 4n 1p 1p 18n 40n)
Aadc [ain] [din] ADC
.model ADC adc_bridge(in_low=.25 in_high=.75 rise_delay=1p fall_delay=1p)
Adrv din dout dout_sink dout_source 0 DRIVER
.model DRIVER sr_bundle_driver(delay=2n out_res=0 min_sink=-.1 max_source=.025 ic=0 inertial_delay=true)
Afam dout dout_sink dout_source %gd(vout 0) FAM
.model FAM sr_family_dac(out_low=0 out_high=5 g_pullup=.024 g_pulldown=.034 g_resistive=.001 g_hiz=1e-8 knee_low=2 knee_high=2.75 v_smooth=.5 input_load=0 t_rise=2n t_fall=2n sink_current=-.01 source_current=.02)
Rload vout 0 10k
.tran 20p 17n
.control
run
wrdata out.dat v(vout)
quit
.endc
.end
