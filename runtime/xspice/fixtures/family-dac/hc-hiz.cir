* Nonlinear family DAC regression: hc-hiz
Vone one 0 1
Vzero zero 0 0
Aadc [one zero] [dhigh ddisabled] ADC
.model ADC adc_bridge(in_low=.25 in_high=.75 rise_delay=1p fall_delay=1p)
Atri dhigh ddisabled dstate TRI
.model TRI d_tristate(delay=1p input_load=0 enable_load=0)
Afam dstate dstate_sink dstate_source %gd(vout 0) FAM
.model FAM sr_family_dac(out_low=0 out_high=5 g_pullup=.024 g_pulldown=.034 g_resistive=.001 g_hiz=1e-8 knee_low=2 knee_high=2.75 v_smooth=.5 input_load=0 t_rise=2n t_fall=2n)
Vtest vout 0 0
.tran 5p 5n
.control
run
wrdata out.dat i(Vtest)
quit
.endc
.end
