* Nonlinear family DAC regression: hc-resistive
Ares din MPULL
.model MPULL d_pullup(load=0)
Afam din din_sink din_source %gd(vout 0) FAM
.model FAM sr_family_dac(out_low=0 out_high=5 g_pullup=.024 g_pulldown=.034 g_resistive=.001 g_hiz=1e-8 knee_low=2 knee_high=2.75 v_smooth=.5 input_load=0 t_rise=2n t_fall=2n)
Vtest vout 0 0
.dc Vtest -1 7 .25
.control
run
wrdata out.dat i(Vtest)
quit
.endc
.end
