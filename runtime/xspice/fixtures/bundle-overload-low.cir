* Hierarchical ALB bundle metadata: low overload, 3 child physical input loads
Vin ain 0 PULSE(1 0 8n 1p 1p 20n 40n)
Aadc [ain] [din] ADC
.model ADC adc_bridge(in_low=.25 in_high=.75 rise_delay=1p fall_delay=1p)
Xshell din din_sink din_source mid mid_sink mid_source SHELL
Xchild0 mid mid_sink mid_source out0 out0_sink out0_source ALB_BUFFER
Xchild1 mid mid_sink mid_source out1 out1_sink out1_source ALB_BUFFER
Xchild2 mid mid_sink mid_source out2 out2_sink out2_source ALB_BUFFER
Adac [mid] [vout] DAC
.model DAC dac_bridge(out_low=0 out_high=1 out_undef=.5 input_load=0 t_rise=1p t_fall=1p)
Rout vout 0 1k
.subckt SHELL sin sin_sink sin_source sout sout_sink sout_source
Xcore sin sin_sink sin_source sout sout_sink sout_source ALB_BUFFER
.ends SHELL
.include "generated.inc"
.tran 2p 22n
.control
run
wrdata generated.dat v(vout)
quit
.endc
.end
