* Rust-compiled ALB timing and strong/HI-Z to family ADC and nonlinear physical HC output
Va ain 0 PULSE(0 1 1n 1p 1p 10n 40n)
Vb bin 0 1
Voe en 0 PULSE(0 1 0.5n 1p 1p 6.5n 40n)
Aadc0 %gd(ain 0) da da_sink da_source ADC
Aadc1 %gd(bin 0) db db_sink db_source ADC
Aadc2 %gd(en 0) de de_sink de_source ADC
.model ADC sr_family_adc(in_low=.25 in_high=.75 rise_delay=1p fall_delay=1p out_low=0 out_high=1 clamp_low=0 clamp_high=1 clamp_bias=.5 clamp_res=10)
Xalb da da_sink da_source db db_sink db_source de de_sink de_source dout dout_sink dout_source ALB_TIMED
Afamily dout dout_sink dout_source %gd(aout 0) HC
.model HC sr_family_dac(out_low=0 out_high=5 g_pullup=.024 g_pulldown=.034 g_resistive=.001 g_hiz=1e-8 knee_low=2 knee_high=2.75 v_smooth=.5 t_rise=2n t_fall=2n input_load=0)
Vmid midpoint 0 2.5
Rpull aout midpoint 100k
Rleak aout 0 1G
.include "generated.inc"
.tran 1p 12n
.control
run
wrdata generated.dat v(aout)
quit
.endc
.end
