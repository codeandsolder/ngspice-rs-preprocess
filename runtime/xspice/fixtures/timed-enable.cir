* Rust-emitted delayed ALB AND plus enable (XSPICE prototype)
Va ain 0 PULSE(0 1 1n 1p 1p 10n 40n)
Vb bin 0 1
Voe en 0 PULSE(0 1 0.5n 1p 1p 6.5n 40n)
Aadc [ain bin en] [da db de] ADC
.model ADC adc_bridge(in_low=.25 in_high=.75 rise_delay=1p fall_delay=1p)
Xalb da da_sink da_source db db_sink db_source de de_sink de_source dout dout_sink dout_source ALB_TIMED
Adac [dout] [aout] DAC
.model DAC dac_bridge(out_low=0 out_high=1 out_undef=.5 input_load=0 t_rise=1p t_fall=1p)
Rout aout 0 1k
.include "generated.inc"
.tran 1p 12n
.control
run
wrdata generated.dat v(aout)
quit
.endc
.end
