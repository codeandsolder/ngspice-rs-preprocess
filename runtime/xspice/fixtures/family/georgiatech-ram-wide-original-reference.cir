* Original public-domain Georgia Tech d_ram: 4-bit x 8-word RAM, select=5.
Vd0 ad0 0 PWL(0 0 18n 0 18.1n 3.3 112n 3.3)
Vd1 ad1 0 PWL(0 3.3 18n 3.3 18.1n 0 112n 0)
Vd2 ad2 0 PWL(0 0 18n 0 18.1n 3.3 112n 3.3)
Vd3 ad3 0 PWL(0 3.3 18n 3.3 18.1n 0 112n 0)
Va0 aa0 0 PWL(0 0 20n 0 20.1n 3.3 52n 3.3 52.1n 0 62n 0 62.1n 3.3 86n 3.3 86.1n 0 112n 0)
Va1 aa1 0 PWL(0 0 74n 0 74.1n 3.3 86n 3.3 86.1n 0 112n 0)
Va2 aa2 0 PWL(0 0 20n 0 20.1n 3.3 52n 3.3 52.1n 0 62n 0 62.1n 3.3 86n 3.3 86.1n 0 112n 0)
Vwe awe 0 PWL(0 0 9n 0 9.1n 3.3 13n 3.3 13.1n 0 25n 0 25.1n 3.3 30n 3.3 30.1n 0 112n 0)
Vs0 as0 0 PWL(0 0 2n 0 2.1n 3.3 93n 3.3 93.1n 0 100n 0 100.1n 3.3 112n 3.3)
Vs1 as1 0 PWL(0 0 40n 0 40.1n 3.3 50n 3.3 50.1n 0 112n 0)
Vs2 as2 0 PWL(0 0 2n 0 2.1n 3.3 112n 3.3)
Ainputs [ad0 ad1 ad2 ad3 aa0 aa1 aa2 awe as0 as1 as2] [d0 d1 d2 d3 a0 a1 a2 we s0 s1 s2] GT_ADC
.model GT_ADC adc_bridge(in_low=1.386 in_high=1.452 rise_delay=1p fall_delay=1p)
Aram [d0 d1 d2 d3] [q0 q1 q2 q3] [a0 a1 a2] we [s0 s1 s2] GT_ORIGINAL_RAM
.model GT_ORIGINAL_RAM d_ram(select_value=5 ic=2 read_delay=600p data_load=0 address_load=0 select_load=0 enable_load=0)
Aout0 q0 q0_sink q0_source %gd(analog_q0 0) RAM_FAMILY
Aout1 q1 q1_sink q1_source %gd(analog_q1 0) RAM_FAMILY
Aout2 q2 q2_sink q2_source %gd(analog_q2 0) RAM_FAMILY
Aout3 q3 q3_sink q3_source %gd(analog_q3 0) RAM_FAMILY
.model RAM_FAMILY sr_family_dac(out_low=0 out_high=3.3 g_pullup=.024 g_pulldown=.034 g_resistive=.001 g_hiz=1e-8 knee_low=2 knee_high=2.75 v_smooth=.5 input_load=0 t_rise=50p t_fall=50p)
Rpull0 vpull analog_q0 1k
Rpull1 vpull analog_q1 1k
Rpull2 vpull analog_q2 1k
Rpull3 vpull analog_q3 1k
Vpull vpull 0 1.2
.tran 20p 112n 0 20p
.control
run
wrdata result.dat i(Vpull) v(analog_q0) v(analog_q1) v(analog_q2) v(analog_q3)
quit
.endc
.end
