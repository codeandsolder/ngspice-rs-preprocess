* Genuine original Georgia Tech ngspice XSPICE d_dlatch digital event model,
* not an analog-coded approximation or user-authored latch state machine.
* Our verified external wrapper adds load-bundle metadata and real analog
* output ports; its internal A latch is the original stock d_dlatch code model.
Vdata analog_data 0 PWL(0 0 8n 0 8.1n 3.3 23n 3.3 23.1n 0 37n 0 37.1n 3.3 48n 3.3 48.1n 0 58n 0 58.1n 3.3 79n 3.3 79.1n 0 92n 0 92.1n 3.3 108n 3.3)
Venable analog_enable 0 PWL(0 0 5n 0 5.1n 3.3 27n 3.3 27.1n 0 42n 0 42.1n 3.3 62n 3.3 62.1n 0 86n 0 86.1n 3.3 110n 3.3)
Vset analog_set 0 PWL(0 0 30n 0 30.1n 3.3 34n 3.3 34.1n 0 67n 0 67.1n 3.3 71n 3.3 71.1n 0 110n 0)
Vreset analog_reset 0 PWL(0 0 51n 0 51.1n 3.3 55n 3.3 55.1n 0 67n 0 67.1n 3.3 75n 3.3 75.1n 0 110n 0)
Adata [analog_data] [data] DL
Aenable [analog_enable] [enable] DL
Aset [analog_set] [set] DL
Areset [analog_reset] [reset] DL
Xexternal data enable set reset analog_q analog_nq GT_ORIGINAL_DIGITAL_LATCH
Rload_q analog_q 0 100k
Rload_nq analog_nq 0 100k
.model DL d_logic_block family="HC" out_delay=1p def="out[0]=in[0];"
.include "native-georgiatech-dlatch.lib"
.tran 20p 110n 0 20p
.control
run
wrdata result.dat v(analog_q) v(analog_nq) v(analog_data) v(analog_enable) v(analog_set) v(analog_reset)
quit
.endc
.end
