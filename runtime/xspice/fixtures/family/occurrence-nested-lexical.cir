* Nested lexical INNER model scoped inside cloned OUTER, with local .param
Vin_a in_a 0 1.5
Vin_b in_b 0 1.5
Vin_c in_c 0 1.5
Xone in_a out_a OUTER
Xtwo in_b out_b OUTER
Xthree in_c out_c OUTER
Rload_a out_a 0 100k
Rload_b out_b 0 100k
Rload_c out_c 0 100k
.subckt OUTER analog_in analog_out
Xinner analog_in analog_out INNER
.subckt INNER pin_in pin_out
.param RMON=100meg
A1 [pin_in] [pin_out] DL
Rmonitor pin_out 0 {RMON}
.model DL d_logic_block input_load=2p out_res=40 out_delay=2n family="HC" def="out[0] = in[0];"
.ends INNER
.ends OUTER
.tran 20p 15n
.control
run
wrdata result.dat v(out_a) v(out_b) v(out_c)
quit
.endc
.end
