* Inner lexical definition holds private ADC/DAC; parent ports stay analog
Xtop o1 OUTER
Rprobe o1 0 100k
.subckt OUTER output
Xinner output INNER
.ends OUTER
.subckt INNER analog_out
Vlocal local_in 0 1.5
A1 [local_in] [local_out] DL
Rmeter local_out analog_out 1m
.model DL d_logic_block input_load=2p out_res=40 out_delay=2n family="HC" def="out[0] = in[0];"
.ends INNER
.tran 20p 15n
.control
run
wrdata result.dat v(o1)
quit
.endc
.end
