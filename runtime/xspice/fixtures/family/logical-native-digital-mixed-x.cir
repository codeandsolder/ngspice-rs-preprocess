* A real external native 7-port X has two digital event bundles and one
* independently wired physical analog pin. The native analog resistor must
* load the 2V-through-1k source down to 1V, not a fictitious digital triple.
Vin analog_input 0 PWL(0 0 2n 0 2.05n 1.5 9n 1.5 9.05n 0 15n 0)
Vtap tap_supply 0 2
Rtap_source tap_supply analog_tap 1k
Ain [analog_input] [first] DL
Xexternal first second analog_tap LEGACY_MIXED_BUFFER
Aout [second] [analog_output] DL
Rload analog_output 0 100k
.model DL d_logic_block family="HC" out_delay=1n def="out[0]=in[0];"
.include "native-external-mixed-buffer.lib"
.tran 20p 15n 0 20p
.control
run
wrdata result.dat v(analog_output) v(analog_tap)
quit
.endc
.end
