* Original TI gate_driver_basic electrical behavior with a deliberate
* digital event adapter. The manufacturer's original "inp" was analog-coded
* 0..1V logic, NOT natively an XSPICE event pin. The native replacement
* explicitly maps its one event bundle to a stock 0/1V dac_bridge.
Vin analog_input 0 PWL(0 0 10n 0 10.5n 3.3 60n 3.3 60.5n 0 110n 0 110.5n 3.3 180n 3.3 180.5n 0 230n 0)
Evendor_control vendor_control 0 analog_input 0 0.303030303030303
Vdd rail 0 3.3
Vload bias 0 PWL(0 0 58n 0 58.5n 3.3 108n 3.3 108.5n 0 175n 0 175.5n 3.3 230n 3.3)
Rload_a bias_load_a node_load_a 200
Vprobe_a node_load_a out_a 0
Rload_b bias_load_b node_load_b 200
Vprobe_b node_load_b out_b 0
Ealias_a bias_load_a 0 bias 0 1
Ealias_b bias_load_b 0 bias 0 1
Acontrol [analog_input] [event_control] DL
Xvendor_a out_a event_control rail 0 TI_TPS22986_GATE_DRIVER PARAMS: tdr=4n tdf=4n ttr=2n ttf=2n rsrc=20 isrc=4m rsnk=30 isnk=6m gmin=1e-10
Xvendor_b out_b event_control rail 0 TI_TPS22986_GATE_DRIVER PARAMS: tdr=7n tdf=6n ttr=4n ttf=3n rsrc=50 isrc=8m rsnk=70 isnk=3m gmin=1e-10
* Both digital control pins share one physical ADC and one original ALB source.
* A distinct physical ALB ADC/DAC observes the original analog driver.
Elevel monitor_in 0 out_a 0 1
Amonitor [monitor_in] [monitor_out] DL
Rmonitor monitor_out 0 100k
.model DL d_logic_block family="HC" out_delay=1p def="out[0]=in[0];"
.include "native-ti-gatedriver.lib"
.tran 50p 230n 0 50p
.control
run
wrdata result.dat v(out_a) i(Vprobe_a) v(out_b) i(Vprobe_b) v(vendor_control) v(bias) v(monitor_out)
wrdata control-result.dat v(xvendor_a.analog_control)
quit
.endc
.end
