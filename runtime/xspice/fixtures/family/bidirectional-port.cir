* Original ALB bus pin is simultaneously an input sensor and a tri-state output.
* The single analog node PIN must not become one shorted digital bundle.
Vext ext 0 PWL(0 0 6n 0 6.1n 3.3 14n 3.3 14.1n 0 40n 0)
Rext ext pin 1k
Voe oe 0 PWL(0 0 18n 0 18.1n 3.3 28n 3.3 28.1n 0 40n 0)
Xone pin oe observe TOP
Robserve observe 0 100k
.subckt TOP pin oe monitor
A1 [pin oe] [pin monitor] DL
.model DL d_logic_block file=logic input_load=2p out_res=40 out_delay=2n family="HC"
.file logic
PORT PIN in[0] ;
PORT OE in[1] ;
PORT DRIVE out[0] ;
PORT MON out[1] ;
COMB (WIDTH=1, DELAY=2n) D ;
D = PIN ;
DRIVE = 1 ;
DRIVE.En = OE ;
MON = D ;
.endf
.ends TOP
.tran 20p 40n
.control
run
wrdata result.dat v(pin) v(observe) v(oe) v(ext)
quit
.endc
.end
