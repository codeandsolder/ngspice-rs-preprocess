* Native generated family ADC -> Rust-compiled ALB BUFFER -> native family DAC.
* Vin=1.5 V is HIGH at 3.3 V HC thresholds (1.386/1.452 V),
* but LOW at 5 V nominal HC thresholds (2.1/2.2 V).
Vin analog_input 0 1.5
Xalb d_in d_in_sink d_in_source d_out d_out_sink d_out_source ALB_BUFFER
Rload analog_output 0 100k
.include "generated.inc"
.include "bridge.inc"
.tran 20p 15n
.control
run
wrdata result.dat v(analog_output)
quit
.endc
.end
