* ALB analog input and output contact ONLY through externally defined X pins.
Vin analog_input 0 1.5
Xinput analog_input inner_signal ANALOG_LINK
A1 [inner_signal] [inner_output] DL
Xoutput inner_output analog_output ANALOG_LINK
Rload analog_output 0 100k
.model DL d_logic_block family="HC" def="out[0]=in[0];"
.include "opaque-analog-link.lib"
.tran 20p 15n
.control
run
wrdata result.dat v(analog_output)
quit
.endc
.end
