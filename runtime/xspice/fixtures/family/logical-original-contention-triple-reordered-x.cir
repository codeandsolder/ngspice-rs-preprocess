* Original ngspice47 1991 digital IDN resolution: triple all 48 table cases
Venable aenable 0 PWL(0 3.3 130n 3.3 130.1n 0 261n 0 261.1n 3.3 392n 3.3)
AINEN [aenable] [len] SOURCE_LOGIC
.model SOURCE_LOGIC d_logic_block family="HC" out_delay=1p def="out[0]=in[0];"
Xexternal len ANALOG_RAW ANALOG_ENABLED ANALOG_GAIN ANALOG_PROBE ORIGINAL_CONTENTION
.include "native-original-contention-triple-reordered.lib"
Rraw ANALOG_RAW 0 1k
Renabled ANALOG_ENABLED 0 1k
Rgain ANALOG_GAIN 0 1k
Craw ANALOG_RAW 0 2p
Cenabled ANALOG_ENABLED 0 2p
Cgain ANALOG_GAIN 0 2p
Vpull vpull 0 1.2
Rprobe vpull ANALOG_PROBE 1k
Cprobe ANALOG_PROBE 0 2p
.tran 25p 391n 0 25p
.control
run
eprint xexternal.qev xexternal.rraw xexternal.rgated xexternal.rgain > original-events.txt
wrdata result.dat v(ANALOG_RAW) v(ANALOG_ENABLED) v(ANALOG_GAIN) v(ANALOG_PROBE) i(Vpull) v(aenable)
quit
.endc
.end
