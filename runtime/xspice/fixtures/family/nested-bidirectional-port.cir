* An analog pin is sensed and driven by different ALBs two X layers below TOP.
* The parent must choose different ADC-input and DAC-output physical triples.
Vext ext 0 PWL(0 0 6n 0 6.1n 3.3 14n 3.3 14.1n 0 40n 0)
Rext ext pin 1k
Vcontrol oe 0 PWL(0 0 18n 0 18.1n 3.3 28n 3.3 28.1n 0 40n 0)
Xone pin oe observe TOP
Robserve observe 0 100k
.subckt TOP pin oe monitor
Xsense pin monitor SENSE_WRAPPER
Xdriver oe pin DRIVE_WRAPPER
.ends TOP
.subckt SENSE_WRAPPER ain mout
Xinner ain mout SENSE
.ends SENSE_WRAPPER
.subckt DRIVE_WRAPPER ctrl drive
Xinner ctrl drive DRIVE
.ends DRIVE_WRAPPER
.subckt SENSE pin observer
A1 [pin] [observer] DS
.model DS d_logic_block def="out[0] = in[0];" input_load=2p out_res=40 out_delay=2n family="HC"
.ends SENSE
.subckt DRIVE oe pin
A2 [oe] [pin] DD
.model DD d_logic_block def="out[0] = in[0];" input_load=2p out_res=40 out_delay=2n family="HC"
.ends DRIVE
.tran 20p 40n
.control
run
wrdata result.dat v(pin) v(observe) v(oe) v(ext)
quit
.endc
.end
