* Real TI TPS22986 nmos_simple: independent analog gate, drain, source.
* Two instances with distinct thresholds, conduction and current limits.
* The original TI model limits positive drain current, not reverse current.
Vin analog_input 0 PWL(0 0 5n 0 5.5n .3 15n .3 15.5n .6 25n .6 25.5n 1.1 40n 1.1 40.5n 1.6 55n 1.6 55.5n 2.3 70n 2.3 70.5n 3.4 90n 3.4 90.5n 4 105n 4 105.5n .2 122n .2 122.5n 3.7 150n 3.7
Vbias supply 0 PWL(0 0 2n 0 4n 1 25n 1 27n 3.3 78n 3.3 80n -1.5 110n -1.5 112n 4 150n 4)
Rfeed_base supply base_feed 150
Vprobe_base base_feed drain_base 0
Rfeed_strong supply strong_feed 150
Vprobe_strong strong_feed drain_strong 0
Xfet_base drain_base analog_input 0 TI_TPS22986_NMOS
Xfet_strong drain_strong analog_input 0 TI_TPS22986_NMOS PARAMS: von=2.4 vth=.4 ron=120 roff=5e8 imax=4m
* An ideal non-loading analog monitor gives a real ALB ADC/DAC path,
* but does not disturb either transistor's signed drain current.
Elevel monitor_in 0 drain_base 0 1
Amonitor [monitor_in] [monitor_out] DL
Rmonitor monitor_out 0 100k
.model DL d_logic_block family="HC" out_delay=1n def="out[0]=in[0];"
.include "native-ti-nmos.lib"
.tran 20p 150n 0 20p
.control
run
wrdata result.dat v(drain_base) i(Vprobe_base) v(drain_strong) i(Vprobe_strong) v(analog_input) v(supply) v(monitor_out)
quit
.endc
.end
