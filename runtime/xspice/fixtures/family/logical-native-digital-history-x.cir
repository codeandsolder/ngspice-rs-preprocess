* Analog UNKNOWN plateau -> verified external digital X -> HC analog output.
* A separate three-stage ALB chain provides a local physical comparison.
* This verifies X bundle propagation, not independent vendor equivalence.
Vin analog_input 0 PWL(0 0 4n 0 4.01n 3.3 14n 3.3 14.01n 2.15 24n 2.15 24.01n 0 31n 0 31.01n 3.3 40n 3.3 40.01n 0 48n 0)
Ain [analog_input] [first] DL
Xexternal first second LEGACY_DIGITAL_BUFFER
Aout [second] [analog_output] DL
Areference_in [analog_input] [reference_first] DL
Areference_mid [reference_first] [reference_second] DL
Areference_out [reference_second] [reference_output] DL
Rload analog_output 0 100k
Rreference reference_output 0 100k
.model DL d_logic_block family="HC" out_delay=1n def="out[0]=in[0];"
.include "native-external-buffer.lib"
.tran 20p 48n 0 20p
.control
run
wrdata result.dat v(analog_output) v(reference_output) v(analog_input)
quit
.endc
.end
