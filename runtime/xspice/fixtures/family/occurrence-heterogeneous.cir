* One shared original ALB model, with analog input on one occurrence and digital input on the other
Vin_a in_a 0 1.5
Vin_b in_b 0 pulse(0 1.5 5n 20p 20p 12n 40n)
Aroot [in_b] [bus] DLROOT
.model DLROOT d_logic_block file=root_logic input_load=2p out_res=40 out_delay=2n family="HC"
.file root_logic
PORT A in[0] ;
PORT Y out[0] ;
COMB (WIDTH=1, DELAY=2n) D ;
D = A ;
Y = D ;
.endf
Xone in_a out_a TOP
Xtwo bus out_b TOP
Rload_a out_a 0 100k
Rload_b out_b 0 100k
.subckt TOP analog_in analog_out
A1 [analog_in] [analog_out] DL
.model DL d_logic_block file=logic input_load=2p out_res=40 out_delay=2n family="HC"
.file logic
PORT A in[0] ;
PORT Y out[0] ;
COMB (WIDTH=1, DELAY=2n) D ;
D = A ;
Y = D ;
.endf
.ends TOP
.tran 20p 30n
.control
run
wrdata result.dat v(out_a) v(out_b)
quit
.endc
.end
