* Two physical input loads share one local ADC; analog input is private
Xone sense TOP
Rprobe sense 0 100k
.subckt TOP sensed
Vin raw 0 PULSE(0 5 1n 1p 1p 30n 60n)
Rin raw local_in 1k
A1 [local_in] [left] DL
A2 [local_in] [right] DL
Bsense sensed 0 V=v(local_in)
.model DL d_logic_block file=logic input_load=2p out_res=40 out_delay=2n family="HC"
.file logic
PORT A in[0] ;
PORT Y out[0] ;
COMB (WIDTH=1, DELAY=2n) D ;
D = A ;
Y = D ;
.endf
.ends TOP
.tran 20p 13n
.control
run
wrdata result.dat v(sense)
quit
.endc
.end
