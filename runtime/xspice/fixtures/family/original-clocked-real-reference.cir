* ORIGINAL ngspice47 source digital real_delay state-sensitive sampling proof
Venable aenable 0 PWL(0 3.3 43n 3.3 43.1n 0 79n 0 79.1n 3.3 114n 3.3)
Aenable [aenable] [EN] ORIGINAL_ADC
.model ORIGINAL_ADC adc_bridge(in_low=1.386 in_high=1.452 rise_delay=1p fall_delay=1p)
AsourceData [DATA] ORIGINAL_DATA
AsourceClock [CLK] ORIGINAL_CLOCK
Ad2r DATA NULL RDATA ORIGINAL_D2R
Ahold RDATA CLK RHELD ORIGINAL_DELAY
Again RHELD RPOST ORIGINAL_GAIN
Aenabled DATA EN RENABLE ORIGINAL_DENABLE
Araw RDATA ANALOG_RAW ORIGINAL_R2V
Aheld RHELD ANALOG_HELD ORIGINAL_R2V
Apost RPOST ANALOG_POST ORIGINAL_R2V
AenProbe RENABLE ANALOG_ENABLED ORIGINAL_R2V
Aprobe DATA Q_SINK Q_SOURCE %gd(ANALOG_PROBE 0) ORIGINAL_PROBE
.model ORIGINAL_DATA d_source(input_file="original-clocked-real-data.txt" input_load=0)
.model ORIGINAL_CLOCK d_source(input_file="original-clocked-real-clock.txt" input_load=0)
.model ORIGINAL_D2R d_to_real(zero=-0.5 one=2 delay=220p)
.model ORIGINAL_DELAY real_delay(delay=610p)
.model ORIGINAL_GAIN real_gain(in_offset=0.25 gain=-0.7 out_offset=0.125 delay=180p ic=0.1)
.model ORIGINAL_DENABLE d_to_real(zero=-0.25 one=1.75 delay=350p)
.model ORIGINAL_R2V real_to_v(gain=1 transition_time=400p)
.model ORIGINAL_PROBE sr_family_dac(out_low=0 out_high=3.3 g_pullup=.024 g_pulldown=.034 g_resistive=.001 g_hiz=1e-8 knee_low=2 knee_high=2.75 v_smooth=.5 input_load=0 t_rise=50p t_fall=50p)
Rraw ANALOG_RAW 0 1k
Rheld ANALOG_HELD 0 1k
Rpost ANALOG_POST 0 1k
Renabled ANALOG_ENABLED 0 1k
Craw ANALOG_RAW 0 2p
Cheld ANALOG_HELD 0 2p
Cpost ANALOG_POST 0 2p
Cenabled ANALOG_ENABLED 0 2p
Vpull vpull 0 1.2
Rprobe vpull ANALOG_PROBE 1k
Cprobe ANALOG_PROBE 0 2p
.tran 25p 112n 0 25p
.control
run
eprint rdata rheld rpost renable data clk > original-events.txt
wrdata result.dat v(ANALOG_RAW) v(ANALOG_HELD) v(ANALOG_POST) v(ANALOG_ENABLED) v(ANALOG_PROBE) i(Vpull) v(aenable)
quit
.endc
.end
