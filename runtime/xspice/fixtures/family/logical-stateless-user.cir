* Explicit stateless USER/USER_SCALE native XSPICE integration source.
* Elements 9.40d currently warns on stateless USER access (vendor
* baseline captured separately), but this fixture checks the documented
* unsigned expression semantics and the real model-level parser path.
Vin analog_input 0 1.5
Xtop analog_input analog_output TOP
Rload analog_output 0 100k
.subckt TOP din dout
A1 [din] [dout] DL
.model DL d_logic_block file=logic input_load=2p out_res=40 out_delay=2n family="HC" user=[0.75] user_scale=3
.file logic
PORT A in[0] ;
PORT Y out[0] ;
Y = (USER[0]>1) ? A : 0 ;
.endf
.ends TOP
.tran 20p 15n
.control
run
wrdata result.dat v(analog_output)
quit
.endc
.end
