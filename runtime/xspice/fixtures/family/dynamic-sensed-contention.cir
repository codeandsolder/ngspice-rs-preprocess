* Native dynamic ALB ADC readback of a physically shared bus.
* Two independently promoted DACs contend while an ALB in the same GROUP
* samples the analog PIN. A MOS-style controlled switch changes the shunt
* load to drive the shared bus into the HC ADC's UNKNOWN threshold band.
Vleft a 0 PWL(0 0 10n 0 10.1n 3.3 88n 3.3 88.1n 0 145n 0)
Vright b 0 PWL(0 0 30n 0 30.1n 3.3 117n 3.3 117.1n 0 145n 0)
Vloadctl gate 0 PWL(0 0 45n 0 45.1n 3.3 72n 3.3 72.1n 0 96n 0 96.1n 3.3 106n 3.3 106.1n 0 145n 0)
Xone pin a b observe TOP
Rload pin 0 100k
Cpin pin 0 80p
Sload pin shunt gate 0 SHUNTSW
Rshunt shunt 0 52
.model SHUNTSW SW(Ron=0.05 Roff=1e12 Vt=1.65 Vh=0.1)
Robserve observe 0 100k
.subckt TOP pin a b observe
Xgateway a b pin observe GATE
Xidle a b spare idle_sense GROUP
.ends TOP
.subckt GATE a b pin observe
Xgroup a b pin observe GROUP
.ends GATE
.subckt GROUP a b pin observe
Xleft a pin OUTER
Xright b pin OUTER
Amonitor [pin] [observe] DM
.model DM d_logic_block def="out[0] = in[0];" input_load=2p out_res=40 out_delay=1n family="HC"
.ends GROUP
.subckt OUTER control drive
Xinner control drive INNER
.ends OUTER
.subckt INNER input output
A1 [input] [output] DL
.model DL d_logic_block def="out[0] = in[0];" input_load=2p out_res=40 out_delay=1n family="HC"
.ends INNER
.tran 20p 145n
.control
run
wrdata result.dat v(pin) v(a) v(b) v(observe) v(gate)
quit
.endc
.end
