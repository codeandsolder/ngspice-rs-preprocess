* Two compiled physical ALB loads share one automatically placed ADC
Vin vin 0 PULSE(0 5 1n 1p 1p 30n 60n)
Rin vin ANALOG_INPUT 1k
Xleft d_in d_in_sink d_in_source d_left d_left_sink d_left_source ALB_BUFFER
Xright d_in d_in_sink d_in_source d_right d_right_sink d_right_source ALB_BUFFER
.include "generated.inc"
.tran 20p 13n
.control
run
wrdata result.dat v(ANALOG_INPUT)
quit
.endc
.end
