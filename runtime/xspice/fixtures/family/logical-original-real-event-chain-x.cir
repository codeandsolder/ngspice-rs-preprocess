* Original ngspice47 XSPICE user-defined real event nodes (stock reference).
Vdata adata 0 PWL(0 0 14n 0 14.1n 3.3 34n 3.3 34.1n 0 54n 0 54.1n 3.3 74n 3.3 74.1n 0 94n 0 94.1n 3.3 115n 3.3 120n 3.3)
Vclock aclock 0 PWL(0 0 22n 0 22.1n 3.3 27n 3.3 27.1n 0 42n 0 42.1n 3.3 47n 3.3 47.1n 0 62n 0 62.1n 3.3 67n 3.3 67.1n 0 82n 0 82.1n 3.3 87n 3.3 87.1n 0 102n 0 102.1n 3.3 107n 3.3 107.1n 0 120n 0)
Adata [adata] [ndata] SOURCE_LOGIC
Aclock [aclock] [nclock] SOURCE_LOGIC
.model SOURCE_LOGIC d_logic_block family="HC" out_delay=1p def="out[0]=in[0];"
Xexternal ndata nclock analog_raw analog_sampled ORIGINAL_REAL_EVENT_CHAIN
.include "native-original-real-event-chain.lib"
Rraw analog_raw 0 1k
Rheld analog_sampled 0 1k
Craw analog_raw 0 2p
Cheld analog_sampled 0 2p
.tran 20p 120n 0 20p
.control
run
wrdata result.dat v(analog_raw) v(analog_sampled) v(adata) v(aclock)
quit
.endc
.end
