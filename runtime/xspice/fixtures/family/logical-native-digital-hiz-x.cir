* Independent native external X built from ngspice d_tristate + family DAC.
* Digital DATA/ENABLE are driven by original ALB outputs through physical ADCs.
* The actual analog X output is pulled toward 1 V through a 10k resistor.
* Released HI_Z should settle to ~0.909 V; enabled HIGH drives ~3.3 V.
Vdata analog_data 0 3.3
Voe analog_enable 0 PWL(0 0 8n 0 8.01n 3.3 18n 3.3 18.01n 0 28n 0 28.01n 3.3 38n 3.3 38.01n 0 47n 0)
Vbias bias 0 1
Rbias bias analog_output 10k
Rload analog_output 0 100k
Adata [analog_data] [data] DL
Aenable [analog_enable] [enable] DL
Xexternal data enable analog_output LEGACY_TRI_DRIVER
.model DL d_logic_block family="HC" out_delay=1n def="out[0]=in[0];"
.include "native-external-tristate.lib"
.tran 20p 47n 0 20p
.control
run
wrdata result.dat v(analog_output) i(Vbias) v(analog_enable)
quit
.endc
.end
