* Three full strength-code sweeps through original 1991 d_source and original real_gain cascade.
* The enable edges exactly coincide with original digital data changes (144ns and 288ns).
Venable aenable 0 PWL(0 3.3 144n 3.3 144.1n 0 288n 0 288.1n 3.3 435n 3.3)
AenInput [aenable] [EN] ORIG_ADC
.model ORIG_ADC adc_bridge(in_low=1.386 in_high=1.452 rise_delay=1p fall_delay=1p)
Astate [QEV] ORIG_STATE
Ad2raw QEV NULL RRAW ORIG_D2R
Ad2gate QEV EN RGATED ORIG_D2R
AgainPos RRAW RPOS ORIG_GAIN_POS
AgainNeg RRAW RNEG ORIG_GAIN_NEG
AgainChain RPOS RCHAIN ORIG_GAIN_CHAIN
Araw RRAW ANALOG_RAW ORIG_R2V
Agated RGATED ANALOG_GATED ORIG_R2V
Apos RPOS ANALOG_POS ORIG_R2V
Aneg RNEG ANALOG_NEG ORIG_R2V
Achain RCHAIN ANALOG_CHAIN ORIG_R2V
Aprobe QEV Q_SINK Q_SOURCE %gd(ANALOG_PROBE 0) PHYSICAL_DAC

.model ORIG_STATE d_source(input_file="original-full-strength-source.txt" input_load=0)
.model ORIG_D2R d_to_real(zero=-0.5 one=2 delay=350p)
.model ORIG_GAIN_POS real_gain(in_offset=0.2 gain=1.6 out_offset=-0.3 delay=250p ic=-0.8)
.model ORIG_GAIN_NEG real_gain(in_offset=0 gain=-1.2 out_offset=0.4 delay=300p ic=1)
.model ORIG_GAIN_CHAIN real_gain(in_offset=-0.1 gain=-0.75 out_offset=0.25 delay=430p ic=-2.3)
.model ORIG_R2V real_to_v(gain=1 transition_time=400p)
.model PHYSICAL_DAC sr_family_dac(out_low=0 out_high=3.3 g_pullup=.024 g_pulldown=.034 g_resistive=.001 g_hiz=1e-8 knee_low=2 knee_high=2.75 v_smooth=.5 input_load=0 t_rise=50p t_fall=50p)
Rraw ANALOG_RAW 0 1k
Rgated ANALOG_GATED 0 1k
Rpos ANALOG_POS 0 1k
Rneg ANALOG_NEG 0 1k
Rchain ANALOG_CHAIN 0 1k
Craw ANALOG_RAW 0 2p
Cgated ANALOG_GATED 0 2p
Cpos ANALOG_POS 0 2p
Cneg ANALOG_NEG 0 2p
Cchain ANALOG_CHAIN 0 2p
Vpull vpull 0 1.2
Rprobe vpull ANALOG_PROBE 1k
Cprobe ANALOG_PROBE 0 2p
.tran 20p 434n 0 20p
.control
run
eprint qev rraw rgated rpos rneg rchain > original-events.txt
wrdata result.dat v(ANALOG_RAW) v(ANALOG_GATED) v(ANALOG_POS) v(ANALOG_NEG) v(ANALOG_CHAIN) v(ANALOG_PROBE) i(Vpull) v(aenable)
quit
.endc
.end
