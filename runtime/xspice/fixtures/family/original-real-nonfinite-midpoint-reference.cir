* Original multi-driven REAL UDN under original 1991 source C models.
* Independent true real UDN resolution must SUM driver contributions.
* Physical ALB enable transitions are offset from original 12ns source boundaries.
Venable aenable 0 PWL(0 3.3 93n 3.3 93.1n 0 189n 0 189.1n 3.3 291n 3.3)
AenInput [aenable] [EN] ORIGINAL_ADC
.model ORIGINAL_ADC adc_bridge(in_low=1.386 in_high=1.452 rise_delay=1p fall_delay=1p)
Asource0 [Q0] ORIGINAL_SOURCE0
Asource1 [Q1] ORIGINAL_SOURCE1
Asource2 [Q2] ORIGINAL_SOURCE2
ArealB Q1 NULL BPRE ORIGINAL_DB
ArealA Q0 NULL REAL_SUM ORIGINAL_DA
AgainB BPRE REAL_SUM ORIGINAL_GAIN_B
ArealC Q2 NULL REAL_SUM ORIGINAL_DC
Ad2enable Q0 EN R_ENABLED ORIGINAL_DENABLE
AgainNonfinite REAL_SUM R_META ORIGINAL_META
Amidpoint Q0 NULL R_MIDPOINT ORIGINAL_MIDPOINT
AmidpointGated Q0 EN R_MIDPOINT_GATED ORIGINAL_MIDPOINT
AgainPost BPRE RPOST ORIGINAL_GAIN_POST
Areadout BPRE ANALOG_SUM ORIGINAL_R2V
Apost RPOST ANALOG_POST ORIGINAL_R2V
Aenabled R_ENABLED ANALOG_ENABLED ORIGINAL_R2V
Aprobe Q0 Q_SINK Q_SOURCE %gd(ANALOG_PROBE 0) ORIGINAL_PROBE
.model ORIGINAL_DA d_to_real(zero=8e307 one=8e307 delay=200p)
.model ORIGINAL_DB d_to_real(zero=1.25 one=-0.75 delay=300p)
.model ORIGINAL_DC d_to_real(zero=-8e307 one=-8e307 delay=700p)
.model ORIGINAL_DENABLE d_to_real(zero=0.25 one=2.25 delay=350p)
.model ORIGINAL_GAIN_B real_gain(in_offset=1e308 gain=1 out_offset=0 delay=240p ic=1e308)
.model ORIGINAL_MIDPOINT d_to_real(zero=1e308 one=1e308 delay=180p)
.model ORIGINAL_META real_gain(in_offset=0 gain=1 out_offset=0 delay=190p ic=0)
.model ORIGINAL_GAIN_POST real_gain(in_offset=0.375 gain=-0.5 out_offset=0.125 delay=180p ic=-1.125)
.model ORIGINAL_R2V real_to_v(gain=1 transition_time=400p)
.model ORIGINAL_PROBE sr_family_dac(out_low=0 out_high=3.3 g_pullup=.024 g_pulldown=.034 g_resistive=.001 g_hiz=1e-8 knee_low=2 knee_high=2.75 v_smooth=.5 input_load=0 t_rise=50p t_fall=50p)
.model ORIGINAL_SOURCE0 d_source(input_file="original-real-sum-driver-0.txt" input_load=0)
.model ORIGINAL_SOURCE1 d_source(input_file="original-real-sum-driver-1.txt" input_load=0)
.model ORIGINAL_SOURCE2 d_source(input_file="original-real-sum-driver-2.txt" input_load=0)
Rsum ANALOG_SUM 0 1k
Rpost ANALOG_POST 0 1k
Renabled ANALOG_ENABLED 0 1k
Csum ANALOG_SUM 0 2p
Cpost ANALOG_POST 0 2p
Cenabled ANALOG_ENABLED 0 2p
Vpull vpull 0 1.2
Rprobe vpull ANALOG_PROBE 1k
Cprobe ANALOG_PROBE 0 2p
.tran 25p 287n 0 25p
.control
run
eprint r_midpoint r_midpoint_gated real_sum r_meta bpre rpost r_enabled q0 q1 q2 > original-events.txt
wrdata result.dat v(ANALOG_SUM) v(ANALOG_POST) v(ANALOG_ENABLED) v(ANALOG_PROBE) i(Vpull) v(aenable)
quit
.endc
.end
