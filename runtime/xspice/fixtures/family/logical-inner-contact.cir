* Analog input resistor lives inside reusable TOP; parent remains analog.
Vin analog_input 0 1.5
Xtop analog_input analog_output TOP
Rload analog_output 0 100k
.subckt TOP din dout
Rin din 0 10k
A1 [din] [dout] DL
.model DL d_logic_block input_load=2p out_res=40 out_delay=2n family="HC" def="out[0]=in[0];"
.ends TOP
.tran 20p 15n
.control
run
wrdata result.dat v(analog_output)
quit
.endc
.end
