* Independent original 2016 Tim Edwards d_genlut multi-output, fanned out
* through original 1991 Georgia Tech d_and and d_xor code models.
Vi0 ai0 0 PWL(0 0 10n 0 10.1n 3.3 30n 3.3 30.1n 0 50n 0 50.1n 3.3 70n 3.3 70.1n 0 90n 0 90.1n 3.3 110n 3.3 110.1n 0 125n 0)
Vi1 ai1 0 PWL(0 0 20n 0 20.1n 3.3 40n 3.3 40.1n 0 60n 0 60.1n 3.3 80n 3.3 80.1n 0 100n 0 100.1n 3.3 120n 3.3 120.1n 0 125n 0)
AIN0 [ai0] [i0] GEN_LOGIC
AIN1 [ai1] [i1] GEN_LOGIC
.model GEN_LOGIC d_logic_block family="HC" out_delay=1p def="out[0]=in[0];"
Xexternal i0 i1 analog_q0 analog_q1 analog_q2 analog_f0 analog_f1 ORIGINAL_GENLUT_FANOUT
.include "native-original-genlut-fanout.lib"
Rpull0 vpull analog_q0 1k
Rpull1 vpull analog_q1 1k
Rpull2 vpull analog_q2 1k
Rpull3 vpull analog_f0 1k
Rpull4 vpull analog_f1 1k
Vpull vpull 0 1.2
.tran 20p 125n 0 20p
.control
run
eprint xexternal.q0_evt xexternal.q1_evt xexternal.q2_evt xexternal.f0_evt xexternal.f1_evt > result.events
wrdata result.dat i(Vpull) v(analog_q0) v(analog_q1) v(analog_q2) v(analog_f0) v(analog_f1)
quit
.endc
.end
