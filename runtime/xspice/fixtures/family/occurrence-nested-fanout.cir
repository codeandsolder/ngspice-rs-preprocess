* One OUTER instance uses two inner same-definition variants
Vin_a in_a 0 1.5
Vin_b in_b 0 1.5
Xtop in_a in_b out_a out_b OUTER
Rload_a out_a 0 100k
Rload_b out_b 0 100k
.subckt OUTER input_a input_b output_a output_b
Xleft input_a output_a INNER
Xright input_b output_b INNER
.subckt INNER pin_in pin_out
A1 [pin_in] [pin_out] DL
.model DL d_logic_block def="out[0] = in[0];" input_load=2p out_res=40 out_delay=2n family="HC"
.ends INNER
.ends OUTER
.tran 20p 15n
.control
run
wrdata result.dat v(out_a) v(out_b)
quit
.endc
.end
