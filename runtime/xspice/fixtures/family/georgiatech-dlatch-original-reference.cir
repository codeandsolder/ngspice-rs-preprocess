* Direct original public-domain Georgia Tech XSPICE d_dlatch code model:
* no external X mapping, no Rust graph translation, no synthetic latch model.
Vdata analog_data 0 PWL(0 0 8n 0 8.1n 3.3 23n 3.3 23.1n 0 37n 0 37.1n 3.3 48n 3.3 48.1n 0 58n 0 58.1n 3.3 79n 3.3 79.1n 0 92n 0 92.1n 3.3 108n 3.3)
Venable analog_enable 0 PWL(0 0 5n 0 5.1n 3.3 27n 3.3 27.1n 0 42n 0 42.1n 3.3 62n 3.3 62.1n 0 86n 0 86.1n 3.3 110n 3.3)
Vset analog_set 0 PWL(0 0 30n 0 30.1n 3.3 34n 3.3 34.1n 0 67n 0 67.1n 3.3 71n 3.3 71.1n 0 110n 0)
Vreset analog_reset 0 PWL(0 0 51n 0 51.1n 3.3 55n 3.3 55.1n 0 67n 0 67.1n 3.3 75n 3.3 75.1n 0 110n 0)
Adata [analog_data] [data] AD
Aenable [analog_enable] [enable] AD
Aset [analog_set] [set] AD
Areset [analog_reset] [reset] AD
.model AD adc_bridge(in_low=1.386 in_high=1.452 rise_delay=1p fall_delay=1p)
Alatch data enable set reset q nq GT_ORIGINAL_LATCH
.model GT_ORIGINAL_LATCH d_dlatch(data_delay=400p enable_delay=900p set_delay=500p reset_delay=650p ic=0 rise_delay=100p fall_delay=200p data_load=0 enable_load=0 set_load=0 reset_load=0)
Aout [q nq] [analog_q analog_nq] GT_ORIGINAL_DAC
.model GT_ORIGINAL_DAC dac_bridge(out_low=0 out_high=3.3 out_undef=1.65 input_load=0 t_rise=50p t_fall=50p)
Rload_q analog_q 0 100k
Rload_nq analog_nq 0 100k
.tran 20p 110n 0 20p
.control
run
wrdata result.dat v(analog_q) v(analog_nq) v(analog_data) v(analog_enable) v(analog_set) v(analog_reset)
quit
.endc
.end
