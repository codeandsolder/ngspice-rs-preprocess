* Conflicting strong ALB outputs sharing one resolved digital bundle
Vhigh high 0 1
Vswitch sw 0 PULSE(0 1 8n 1p 1p 12n 40n)
Aadc [high sw] [dhi dsw] ADC
.model ADC adc_bridge(in_low=.25 in_high=.75 rise_delay=1p fall_delay=1p)
Xhigh dhi dhi_sink dhi_source shared shared_sink shared_source ALB_BUFFER
Xlow dsw dsw_sink dsw_source shared shared_sink shared_source ALB_BUFFER
Adac [shared] [vout] DAC
.model DAC dac_bridge(out_low=0 out_high=1 out_undef=.5 input_load=0 t_rise=1p t_fall=1p)
Rout vout 0 1k
.include "generated.inc"
.tran 2p 18n
.control
run
wrdata generated.dat v(vout)
quit
.endc
.end
