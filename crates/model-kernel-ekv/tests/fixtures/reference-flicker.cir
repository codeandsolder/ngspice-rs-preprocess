EKV independent witness
.options abstol=1e-22 reltol=1e-10 vntol=1e-12
.model ekv ekv_va type=1 vto=0.5 kf=1e-25 af=1.2 l=1u w=10u xd_js=0 xd_jsw=0 xd_jswg=0 xd_cj=0 xd_cjsw=0 xd_cjswg=0
Vd d 0 1
Vg g 0 0.75 AC 1
Vs s 0 0
Vb b 0 0
N1 d g s b ekv
Fout out 0 Vd 1
Rout out 0 1 noisy=0
.control
pre_osdi ./ekv.osdi
noise v(out) Vg dec 1 1 1000000 1
set wr_singlescale
set wr_vecnames
set numdgt=16
setplot noise1
wrdata reference-flicker.tsv onoise_spectrum
quit
.endc
.end
