TINA export style: scope and first-order transfer
.param scale=10 gain=100
.include filter.lib
Vinput in 0 DC 1 AC 1 PULSE(0 1 0 1n 1n 1m 2m)
Xone in out filter PARAMS: rbase=500
Xtwo in other filter PARAMS
+ : rbase=1k
.op
.dc Vinput 0 1 0.25
.ac lin 3 1000 3000
.tran 1u 200u 0 1u uic
.end
