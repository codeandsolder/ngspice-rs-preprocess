* semiconductor diode AC witnesses
Vx x 0 DC 0 AC 1
V0 x a0 0
D0 a0 0 m0
.model m0 D(Is=1e-12 N=1.5 Cjo=1n Vj=.7 M=.4 Tt=5n)
V1 x a1 0
D1 a1 0 m1
.model m1 D(Is=1e-12 N=1.5 Cjo=1n Vj=.7 M=.4)
V2 x a2 0
D2 a2 0 m2
.model m2 D(Is=1e-12 N=1.5 Tt=5n)
V3 x a3 0
D3 a3 0 m3
.model m3 D(Is=1e-12 N=1.5 Isr=1e-10 Nr=2 Cjo=1n Vj=.7 M=.4 Tt=5n)
V4 x a4 0
D4 a4 0 m4
.model m4 D(Is=1e-12 N=1.5 Isr=1e-10 Nr=2 Cjo=1n Vj=.7 M=.4)
V5 x a5 0
D5 a5 0 m5
.model m5 D(Is=1e-12 N=1.5 Ikf=.01 Cjo=1n Vj=.7 M=.4 Tt=5n)
V6 x a6 0
D6 a6 0 m6
.model m6 D(Is=1e-12 N=1.5 Ikf=.01 Cjo=1n Vj=.7 M=.4)
V7 x a7 0
D7 a7 0 m7
.model m7 D(Is=1e-12 N=1.5 BV=3 Ibv=1m Nbv=2 Cjo=1n Vj=.7 M=.4 Tt=5n)
V8 x a8 0
D8 a8 0 m8
.model m8 D(Is=1e-12 N=1.5 BV=3 Ibv=1m Nbv=2 Cjo=1n Vj=.7 M=.4)
V9 x a9 0
D9 a9 0 m9 2
.model m9 D(Is=1e-12 N=1.5 Cjo=1n Vj=.7 M=.4 Tt=5n)
V10 x a10 0
D10 a10 0 m10 m=2
.model m10 D(Is=1e-12 N=1.5 Cjo=1n Vj=.7 M=.4 Tt=5n)
V11 x a11 0
D11 a11 0 m11 n=2
.model m11 D(Is=1e-12 N=1.5 Cjo=1n Vj=.7 M=.4 Tt=5n)
V12 x a12 0
D12 a12 0 m12 m=2 n=2
.model m12 D(Is=1e-12 N=1.5 Cjo=1n Vj=.7 M=.4 Tt=5n)
V13 x a13 0
D13 a13 0 m13 temp=100
.model m13 D(Is=1e-12 N=1.5 Cjo=1n Vj=.7 M=.4 Tt=5n)
V14 x a14 0
D14 a14 0 m14 temp=100
.model m14 D(Is=1e-12 N=1.5 Cjo=1n Vj=.7 M=.4)
V15 x a15 0
D15 a15 0 m15 temp=-40
.model m15 D(Is=1e-12 N=1.5 Cjo=1n Vj=.7 M=.4 Tt=5n)
V16 x a16 0
D16 a16 0 m16 temp=-40
.model m16 D(Is=1e-12 N=1.5 Cjo=1n Vj=.7 M=.4)
V17 x a17 0
D17 a17 0 m17
.model m17 D(Is=1e-12 N=1.5 Isw=1e-10 Ns=2 Cjsw=2n Perim=2)
V18 x a18 0
D18 a18 0 m18 pj=2
.model m18 D(Is=1e-12 N=1.5 Isw=1e-10 Ns=2 Cjsw=2n)
V19 x a19 0
D19 a19 0 m19 perim=2
.model m19 D(Is=1e-12 N=1.5 Isw=1e-10 Ns=2 Cjsw=2n)
V20 x a20 0
D20 a20 0 m20 2 m=2 n=2
.model m20 D(Is=1e-12 N=1.5 Isw=1e-10 Ns=2 Cjsw=2n Perim=2)
V21 x a21 0
D21 a21 0 m21
.model m21 D(Is=1e-12 N=1.5 Isw=1e-10 Ns=2 Cjsw=2n Perim=2 Rsw=4)
V22 x a22 0
D22 a22 0 m22 0
.model m22 D(Is=1e-12 N=1.5 Cjo=1n Vj=.7 M=.4 Tt=5n)
V23 x a23 0
D23 a23 0 m23 m=-2
.model m23 D(Is=1e-12 N=1.5 Cjo=1n Vj=.7 M=.4 Tt=5n)
V24 x a24 0
D24 a24 0 m24 n=-2
.model m24 D(Is=1e-12 N=1.5 Cjo=1n Vj=.7 M=.4 Tt=5n)
.options gmin=1e-12 reltol=1e-10 abstol=1e-14 vntol=1e-12 plotwinsize=0 numdgt=15
.ac lin 3 1k 1Meg
.end
