* Sidewall raw negative N and zero N
Vx x 0 DC 0 AC 1
V0 x a0 0
D0 a0 0 m0 temp=-40
.model m0 D(Is=0 Isw=1e-10 Perim=2 Cjsw=1n N=-1)
V1 x a1 0
D1 a1 0 m1 temp=-40
.model m1 D(Is=0 Isw=1e-10 Perim=2 Cjsw=1n N=-.5)
V2 x a2 0
D2 a2 0 m2 temp=-40
.model m2 D(Is=0 Isw=1e-10 Perim=2 Cjsw=1n N=0)
V3 x a3 0
D3 a3 0 m3 temp=-40
.model m3 D(Is=0 Isw=1e-10 Perim=2 Cjsw=1n N=.05)
V4 x a4 0
D4 a4 0 m4 temp=-40
.model m4 D(Is=0 Isw=1e-10 Perim=2 Cjsw=1n N=3 Ns=-1)
V5 x a5 0
D5 a5 0 m5 temp=-40
.model m5 D(Is=0 Isw=1e-10 Perim=2 Cjsw=1n N=3 Ns=0)
V6 x a6 0
D6 a6 0 m6 temp=27
.model m6 D(Is=0 Isw=1e-10 Perim=2 Cjsw=1n N=-1)
V7 x a7 0
D7 a7 0 m7 temp=27
.model m7 D(Is=0 Isw=1e-10 Perim=2 Cjsw=1n N=-.5)
V8 x a8 0
D8 a8 0 m8 temp=27
.model m8 D(Is=0 Isw=1e-10 Perim=2 Cjsw=1n N=0)
V9 x a9 0
D9 a9 0 m9 temp=27
.model m9 D(Is=0 Isw=1e-10 Perim=2 Cjsw=1n N=.05)
V10 x a10 0
D10 a10 0 m10 temp=27
.model m10 D(Is=0 Isw=1e-10 Perim=2 Cjsw=1n N=3 Ns=-1)
V11 x a11 0
D11 a11 0 m11 temp=27
.model m11 D(Is=0 Isw=1e-10 Perim=2 Cjsw=1n N=3 Ns=0)
.options gmin=1e-12 reltol=1e-10 abstol=1e-14 vntol=1e-12 plotwinsize=0 numdgt=15
.save I(V0) I(V1) I(V2) I(V3) I(V4) I(V5) I(V6) I(V7) I(V8) I(V9) I(V10) I(V11)
.dc Vx -.2 .2 .05
.end
