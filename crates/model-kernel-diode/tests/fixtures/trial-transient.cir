Large step on Shockley diode and external capacitor
Vdrive in 0 PWL(0 -2 1u -2 1.1u 1000 3u 1000 3.1u -2 8u -2)
R1 in out 1k
D1 out 0 dtest
C1 out 0 1n
.model dtest D (IS=1e-14 N=1)
.temp 27
.options reltol=1e-9 abstol=1e-14 vntol=1e-10 gmin=1e-15 method=gear
.control
set numdgt=15
tran 0.5n 8u 0 0.5n
meas tran ramp_up find v(out) at=1.05u
meas tran high find v(out) at=2u
meas tran ramp_down find v(out) at=3.05u
meas tran recovery1 find v(out) at=3.5u
meas tran recovery2 find v(out) at=4u
meas tran low find v(out) at=7u
quit
.endc
.end
