* FN capacitance on linear voltage ramp
Vx x 0 PWL(0 -5 1 -4 2 -4 3 -5)
D1 x 0 dm L=2 W=3 m=2 n=2
.model dm D(level=2 Tox=50)
.options method=gear reltol=1e-10 abstol=1e-14 vntol=1e-12 plotwinsize=0 numdgt=15
.save V(x) I(Vx) I(D1)
.tran 0 3 0 .002
.end
