Extreme diode load line, common Shockley model
Vdrive in 0 DC 1000
R1 in out 1k
D1 out 0 dtest
.model dtest D (IS=1e-14 N=1)
.temp 27
.options reltol=1e-10 abstol=1e-15 vntol=1e-12 gmin=1e-15
.control
set numdgt=15
op
print v(out)
quit
.endc
.end
