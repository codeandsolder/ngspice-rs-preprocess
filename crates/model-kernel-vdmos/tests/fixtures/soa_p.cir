* SOA p reference
Vd d 0 -1
Vg g 0 -5
M1 d g 0 test
.model test VDMOS (vto=3 kp=2 pchan vto=-3 vgs_max=2 vgsr_max=10 vgd_max=2 vgdr_max=10 vds_max=0.5 id_max=-1 idr_max=-1 pd_max=1 tnom=27 derating=0.02 phi=0.8)
.temp 77
.control
set numdgt=17
op
print @m1[id] @m1[idio] @test[phi] @test[pd_max]
.endc
.end
