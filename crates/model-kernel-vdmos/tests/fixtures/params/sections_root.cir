Nested sections in same source library
.lib sections_parts.lib merged
Vg g 0 4
Vd d 0 .25
M1 d g 0 dut
.control
op
print @m1[id] @m1[gm] @m1[gds]
quit
.endc
.end
