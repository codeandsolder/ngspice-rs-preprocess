SPICE param resolution golden
.param k=1.5
.param b={2*k}
.param power={2^3}
.param tern={k>1 ? .5 : 1}
Vg g 0 4
Vd d 0 .25
M1 d g 0 dut
.model dut VDMOS(Vto=3 Kp={b} Lambda={power/1000} theta={tern/10})
.control
op
print @m1[id] @m1[gm] @m1[gds]
quit
.endc
.end
