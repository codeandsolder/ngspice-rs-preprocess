Native ngspice 47 linked model source golden
.include "linked_inner.inc"
.lib "linked_devices.lib" power
Vg g 0 4
Vd d 0 .25
M1 d g 0 dut
.control
op
print @m1[id] @m1[gm] @m1[gds]
quit
.endc
.end
