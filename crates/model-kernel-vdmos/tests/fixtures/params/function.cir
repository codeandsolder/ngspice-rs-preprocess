SPICE custom user function model parameter golden
.func twice(x) {2*x}
.func weighted(x,y) {twice(x)+y}
.param base=2
.param gain={weighted(base,1)}
Vg g 0 4
Vd d 0 .25
M1 d g 0 dut
.model dut VDMOS (Vto=3 Kp={gain} Lambda=0.001)
.control
op
print @m1[id] @m1[gm] @m1[gds]
quit
.endc
.end
