SPICE param scope golden
.param gain=2
Vg g 0 4
Vd d 0 .25
X1 d g 0 blk params: gain={gain*2}
X2 d g 0 blk
.subckt blk d g s params: gain=1
M1 d g s dut
.model dut vdmos(vto=3 kp={gain})
.ends blk
.control
op
print i(vd) @m.x1.m1[id] @m.x2.m1[id]
quit
.endc
.end
