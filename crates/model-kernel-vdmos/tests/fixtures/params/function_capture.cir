Function scope capture golden
.param gain=2
.func gainfn(x) {gain*x}
Vg g 0 4
Vd d 0 .25
X1 d g 0 stage params: gain=4
X2 d g 0 stage
.subckt stage d g s params: gain=1
M1 d g s dut
.model dut vdmos(vto=3 kp={gainfn(1)})
.ends stage
.control
op
print @m.x1.m1[id] @m.x2.m1[id]
quit
.endc
.end
