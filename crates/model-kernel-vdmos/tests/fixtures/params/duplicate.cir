SPICE duplicate param chronology golden
.param a=2
.param b={a}
.param a=3
Vg g 0 4
Vd d 0 .25
M1 d g 0 dut
.model dut vdmos(vto=3 kp={b})
.control
op
print @m1[id]
quit
.endc
.end
