SPICE subcircuit-local custom function model golden
.param scale=2
.func adjust(x) {x*scale}
Vg g 0 4
Vd d 0 .25
X1 d g 0 blk params: gain=4
X2 d g 0 blk
.subckt blk d g s params: gain=1
.func adjustlocal(x) {adjust(x)*gain}
M1 d g s dut
.model dut vdmos(vto=3 kp={adjustlocal(1)})
.ends blk
.control
op
print @m.x1.m1[id] @m.x2.m1[id]
quit
.endc
.end
