Global parameter forward capture
.param gain=2
.param base={gain*2}
Vg g 0 4
Vd d 0 .25
X1 d g 0 stage params: gain=4
X2 d g 0 stage
.subckt stage d g s params: gain=1
M1 d g s dut
.model dut vdmos(vto=3 kp={base})
.ends stage
.control
op
print @m.x1.m1[id] @m.x2.m1[id]
quit
.endc
.end
