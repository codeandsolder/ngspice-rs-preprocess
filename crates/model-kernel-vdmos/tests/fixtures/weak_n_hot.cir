ngspice 47 weak inversion / triode / temperature channel sweep
.options gmin=1e-20 temp=70
Vg g 0 0
Vd d 0 0.15
M1 d g 0 dut
.model dut vdmos (vto=3 kp=20 ksubthres=0.08 subshift=0.12 theta=0.09 lambda=0.006 mtriode=1.2)
.control
set width=200
save v(g) @m1[id] @m1[gm] @m1[gds]
dc Vg 1 5 0.5
print v(g) @m1[id] @m1[gm] @m1[gds]
quit
.endc
.end
