ngspice 47 nonlinear VDMOS gate-charge switching transient
.options gmin=1e-20 reltol=1e-7 abstol=1e-14 method=trap
Vg g 0 PWL(0 0 50n 0 60n -6 100n -6 110n 0 150n 0)
Vd d 0 -0.3
M1 d g 0 dut
.model dut vdmosp (vto=-3 kp=10 cgdmin=20p cgdmax=2n a=1 cgs=1.4n)
.control
set width=200
save v(g) @m1[qgd] @m1[qgs]
tran 0.5n 150n 0 0.5n
print time v(g) @m1[qgd] @m1[qgs]
quit
.endc
.end
