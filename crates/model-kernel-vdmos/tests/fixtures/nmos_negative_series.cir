ngspice 47 nonpositive model series resistance means absent branch
.options gmin=1e-20
Vg g 0 4
Vd d 0 .25
M1 d g 0 dut
.model dut vdmos (vto=3 kp=20 rd=-.02 rs=-.01 rg=-1 rb=-.001)
.control
op
print @m1[id] @m1[gm] @m1[gds]
quit
.endc
.end
