VDMOS 47 physical oracle
Vg g 0 4
Vd d 0 0.25
M1 d g 0 dut
.model dut vdmos (vto=3 kp=20 ksubthres=0.1 subshift=0 lambda=0 theta=0 mtriode=1 cgdmin=2e-11 cgdmax=2e-9 cgs=1.4e-9)
.control
op
print v(d) v(g) @m1[id] @m1[gm] @m1[gds] @m1[qgd]
quit
.endc
.end
